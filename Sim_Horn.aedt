# Ansys Electronics Desktop project, version 2025.2
materials:
  vacuum: permittivity=1
  pec: conductivity=1e+30

design HornPyramidal_ATK (HFSS, HFSS Hybrid Modal Network, model units meter)
options: Allow_Material_Override Save_Adaptive_support_files open_region{BoundaryType=0 OpFreq=1.4204GHz}
variables:
  # --Antenna Dimensions
  Horn_a = 12.67in
  Horn_b = 9.86in
  Horn_length = 21.12in
  # --Standard Waveguide
  WG_a = 6.5in
  WG_b = 3.25in
  WG_Wall_Thickness = 0.08in
  WG_length = 7.04in
geometry:
  NewObject_YQXFTE = box(corner=(-WG_a/2, -WG_b/2, -WG_length), size=(WG_a, WG_b, WG_length))
  NewObject_BN1MHJ = box(corner=(-WG_a/2-WG_Wall_Thickness, -WG_b/2-WG_Wall_Thickness, -WG_length), size=(WG_a+2*WG_Wall_Thickness, WG_b+2*WG_Wall_Thickness, WG_length))
  NewObject_BN1MHJ.subtract(NewObject_YQXFTE)
  WG_inner [vacuum] = box(corner=(-WG_a/2, -WG_b/2, -WG_length), size=(WG_a, WG_b, WG_length))
  Port_Cap [pec] = box(corner=(-WG_a/2-WG_Wall_Thickness, -WG_b/2-WG_Wall_Thickness, -WG_length), size=(WG_a+2*WG_Wall_Thickness, WG_b+2*WG_Wall_Thickness, -WG_Wall_Thickness))
  port1 = rectangle(corner=(-WG_a/2, -WG_b/2, -WG_length), x_size=WG_a, y_size=WG_b)
  NewObject_V4FRE8 = rectangle(corner=(-WG_a/2, -WG_b/2, 0meter), x_size=WG_a, y_size=WG_b)
  NewObject_XNFDHV = rectangle(corner=(-WG_a/2-WG_Wall_Thickness, -WG_b/2-WG_WALL_Thickness, 0meter), x_size=WG_a+2*WG_Wall_Thickness, y_size=WG_b+2*WG_Wall_Thickness)
  NewObject_3DFY90 = rectangle(corner=(-Horn_a/2, -Horn_b/2, Horn_Length), x_size=Horn_a, y_size=Horn_b)
  Horn [pec] = rectangle(corner=(-Horn_a/2-WG_Wall_Thickness, -Horn_b/2-WG_WALL_Thickness, Horn_Length), x_size=Horn_a+2*WG_Wall_Thickness, y_size=Horn_b+2*WG_Wall_Thickness)
  Horn.connect(NewObject_XNFDHV)
  NewObject_V4FRE8.connect(NewObject_3DFY90)
  Horn.subtract(NewObject_V4FRE8)
  Horn.unite(NewObject_BN1MHJ)
  NewObject_ZEJNWL = rectangle(corner=(-WG_a/2, -WG_b/2, 0meter), x_size=WG_a, y_size=WG_b)
  NewObject_KDBEZL = rectangle(corner=(-Horn_a/2, -Horn_b/2, Horn_Length), x_size=Horn_a, y_size=Horn_b)
  NewObject_ZEJNWL.connect(NewObject_KDBEZL)
  WG_inner.unite(NewObject_ZEJNWL)
  RadiatingSurface [vacuum] = region(absolute_offset=0.070402703meter on all sides)
boundaries and excitations:
  AutoOpen1: Radiation Objects=RadiatingSurface
  p1: Wave Port Objects=port1 WavePortType=Modal NumModes=1 Modes{Mode1{IntLine{(0, -0.041275, -0.178816) -> (0, 0.041275, -0.178816)} CharImp=wave}}
setups:
  ATK_Solution: HfssDriven Frequency=1.4204GHz MaxDeltaS=0.02 MaximumPasses=15 MinimumPasses=1 MinimumConvergedPasses=1 PercentRefinement=30 BasisOrder=1 PortAccuracy=2 DrivenSolverType="Direct Solver" IESolverType=ACA
    sweep FF_Sweep: 0.7102GHz to 2.1306GHz, 3 points; Type=Discrete SaveFields
    sweep SParam_Sweep: 0.7102GHz to 2.1306GHz, 100 points; Type=Interpolating InterpTolerance=0.5 InterpMaxSolns=250 InterpUsePortImped=false PassivityErrorTolerance=0.0001
source amplitudes:
  p1:1: 1W 0deg
radiation setups:
  3D: Infinite Sphere Theta=0deg..180deg step 2deg Phi=-180deg..180deg step 2deg
  Elevation: Infinite Sphere Theta=-180deg..180deg step 1deg Phi=0deg..90deg step 90deg
  Azimuth: Infinite Sphere Theta=90deg..90deg step 0deg Phi=-180deg..180deg step 1deg
  ATK_2D: Infinite Sphere Theta=-180deg..180deg step 1deg Phi=0deg..90deg step 90deg
  ATK_3D: Infinite Sphere Theta=-180deg..180deg step 2deg Phi=0deg..180deg step 5deg
field plots:
  Mag_E1: E Field over a plane on ATK_Solution : FF_Sweep at Freq=1.4204GHz Phase=0deg
reports:
  ff_3D_GainTotal: dB(GainTotal) vs Phi, Theta on ATK_Solution : LastAdaptive, ATK_3D [Freq=1.4204e+09]
  ff_2D_GainTotal: dB(GainTotal) vs Theta on ATK_Solution : LastAdaptive, ATK_2D [Phi=all Freq=1.4204e+09]
  ff_2D_GainTotal_Stacked: dB(GainTotal) vs Theta on ATK_Solution : FF_Sweep, ATK_2D [Phi=all Freq=all]
  Return Loss: dB(St11) vs Freq on ATK_Solution : SParam_Sweep
  Input Impedance: St11 on ATK_Solution : SParam_Sweep [Freq=all]
